// tb_ota2s_sugg.scs (SKY130) -- the compensation network CircuitInsight's
// suggest_compensation(goal='pm', 60 deg) ranked FIRST on area for this
// amplifier: series 3.177302 pF + 3747.635 ohm across the Miller pair
// (realized through the schematic's Cc/Rz chain). Tool-predicted PM:
// 66.74 deg through the Tian probe. Spectre stb confirms below.
// spectre tb_ota2s_sugg.scs -format psfascii -raw ./psf_sugg +log sugg.log
simulator lang=spectre
global 0 vdd!
parameters temperature=27
include "<pdk-models>" section=tt

// analogLib/ideal_balun/schematic
subckt ideal_balun d c p n
    K0 (d 0 p c) transformer n1=2
    K1 (d 0 c n) transformer n1=2
ends ideal_balun

// worklib/ota2s/schematic
subckt ota2s out vdd inp inn vss vbn
    MN3 (out vbn vss vss) nfet_01v8 w=(40u) l=1u m=(4)*(1)
    MN2 (tail vbn vss vss) nfet_01v8 w=(40u) l=1u m=(2)*(1)
    MN1 (outd inp tail vss) nfet_01v8 w=(40u) l=2u m=(1)*(1)
    MN0 (mirr inn tail vss) nfet_01v8 w=(40u) l=2u m=(1)*(1)
    Cc (net1 out) capacitor c=3.177302p
    Rz (outd net1) resistor r=3747.635
    MP2 (out outd vdd vdd) pfet_01v8 w=(40u) l=1u m=(4)*(1)
    MP1 (outd mirr vdd vdd) pfet_01v8 w=(40u) l=2u m=(2)*(1)
    MP0 (mirr mirr vdd vdd) pfet_01v8 w=(40u) l=2u m=(2)*(1)
ends ota2s

// worklib/tb_ota2s/schematic
CL (vout 0) capacitor c=5p
VIND (vin_dm 0) vsource dc=0 mag=1 type=dc
VINC (vin_cm 0) vsource dc=900.0m type=dc
VSUP (vdd! 0) vsource dc=1.8 type=dc
I5 (vin_dm vin_cm vin_p net1) ideal_balun
IB (vdd! vbn) isource dc=40u type=dc
IPRB0 (vout vin_n) iprobe
I0 (vout vdd! vin_p vin_n 0 vbn) ota2s
MN2 (vbn vbn 0 0) nfet_01v8 w=(40u) l=1u m=(2)*(1)
simulatorOptions options temp=27
stb stb start=1m stop=10G dec=20 probe=IPRB0
dcOp dc
