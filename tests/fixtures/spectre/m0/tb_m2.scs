// tb_m2.scs -- hierarchical M2 validation (SKY130): mirrors
// worklib/tb_m2/schematic (the tb_hier.cin.json exporter fixture).
// Instance names must match the schematic so dcOpInfo joins the exporter's
// CIN: expect I7.M1, I7.RL. -> psf_tbm2/
//
//   spectre tb_m2.scs -format psfascii -raw ./psf_tbm2 +log tbm2.log

simulator lang=spectre
global 0
include "<pdk-models>" section=tt
parameters temperature=27

subckt csstage (in out vddl)
    M1 (out in 0 0) nfet_01v8 w=(2u) l=180n as=530f ad=530f ps=4.53u \
            pd=4.53u nrd=0.170000 nrs=0.170000 m=(1)*(1)
    RL (vddl out) resistor r=10K
ends csstage

VDD  (vdd 0)  vsource dc=1.8  type=dc
VIN  (vin 0)  vsource dc=800m mag=1 type=dc
VINP (vinp 0) vsource dc=790m type=dc

RD1 (vdd vmid) resistor r=100K
RD2 (vmid 0)   resistor r=100K

I7 (vin net1 vdd) csstage
C0 (net1 0) capacitor c=100f

M2 (voutp vinp vdd vdd) pfet_01v8 w=(4u) l=180n as=1.06p ad=1.06p ps=8.53u \
        pd=8.53u nrd=0.085000 nrs=0.085000 m=(1)*(1)
RLP (voutp 0) resistor r=10K

simulatorOptions options temp=27 tnom=27 gmin=1e-12 maxnotes=5 maxwarns=5
dcOp     dc   maxiters=150 annotate=status
dcOpInfo info what=oppoint where=rawfile
ac       ac   start=1k stop=10G dec=20 annotate=status
saveOptions options save=allpub
